.title KiCad schematic
.include "/home/opensuse/Documents/ELECTRONICS-ENGINEERING/CUSTOM-DESIGN/X-AUDIO/X-B350W-4-LITE-350W-CLASS-B-POWER-AMP-MAIN-CIRCUIT/SPICE-MODELS/1N4007.LIB"
.include "/home/opensuse/Documents/ELECTRONICS-ENGINEERING/CUSTOM-DESIGN/X-AUDIO/X-B350W-4-LITE-350W-CLASS-B-POWER-AMP-MAIN-CIRCUIT/SPICE-MODELS/1N4148.LIB"
.include "/home/opensuse/Documents/ELECTRONICS-ENGINEERING/CUSTOM-DESIGN/X-AUDIO/X-B350W-4-LITE-350W-CLASS-B-POWER-AMP-MAIN-CIRCUIT/SPICE-MODELS/2N5401.LIB"
.include "/home/opensuse/Documents/ELECTRONICS-ENGINEERING/CUSTOM-DESIGN/X-AUDIO/X-B350W-4-LITE-350W-CLASS-B-POWER-AMP-MAIN-CIRCUIT/SPICE-MODELS/2N5551.LIB"
.include "/home/opensuse/Documents/ELECTRONICS-ENGINEERING/CUSTOM-DESIGN/X-AUDIO/X-B350W-4-LITE-350W-CLASS-B-POWER-AMP-MAIN-CIRCUIT/SPICE-MODELS/2SA1943.LIB"
.include "/home/opensuse/Documents/ELECTRONICS-ENGINEERING/CUSTOM-DESIGN/X-AUDIO/X-B350W-4-LITE-350W-CLASS-B-POWER-AMP-MAIN-CIRCUIT/SPICE-MODELS/2SC5200.LIB"
.include "/home/opensuse/Documents/ELECTRONICS-ENGINEERING/CUSTOM-DESIGN/X-AUDIO/X-B350W-4-LITE-350W-CLASS-B-POWER-AMP-MAIN-CIRCUIT/SPICE-MODELS/MJE15034.LIB"
.include "/home/opensuse/Documents/ELECTRONICS-ENGINEERING/CUSTOM-DESIGN/X-AUDIO/X-B350W-4-LITE-350W-CLASS-B-POWER-AMP-MAIN-CIRCUIT/SPICE-MODELS/MJE15035.LIB"
.include "/home/opensuse/Documents/ELECTRONICS-ENGINEERING/CUSTOM-DESIGN/X-AUDIO/X-B350W-4-LITE-350W-CLASS-B-POWER-AMP-MAIN-CIRCUIT/SPICE-MODELS/POTENTIOMETER.LIB"
.options abstol=1u
.options reltol=0.01
.title X-B350W-4-LITE SIMPLIFIED 350W CLASS-B POWER AMPLIFIER MAIN-CIRCUIT FOR 4-OHMS OUTPUT LOAD
.PARAM BIAS=0.333
.PARAM OFFSET=0.333
RG1 0 AGND 0.001
RLOAD1 OUTPUT 0 4
V3 INPUT AGND dc 0 ac 1 sin(0 1.096 1K 0 0)
V1 +62V 0 DC 62
V2 -62V 0 DC -62V
Q4006 Net-_Q4006-C_ Net-_Q4002-C_ Net-_D4003-A_ 2N5551
Q4003 Net-_Q4003-C_ Net-_Q4003-B_ Net-_Q4003-E_ 2N5401
R4010 Net-_Q4003-B_ Net-_C4005-Pad1_ 620
R4008 Net-_C4006-Pad1_ Net-_Q4003-B_ 30k
RWJ4003 Net-_C4006-Pad1_ PW_OUT 0.001
XRT4001 Net-_Q4002-E_ Net-_R4006-Pad2_ Net-_Q4003-E_ rpot value=5k pos={OFFSET}
R4004 Net-_Q4001-C_ Net-_Q4002-E_ 27
C4003 Net-_Q4002-B_ Net-_C4003-Pad2_ 470u
Q4002 Net-_Q4002-C_ Net-_Q4002-B_ Net-_Q4002-E_ 2N5401
R4009 Net-_C4003-Pad2_ INPUT 620
R4007 Net-_Q4002-B_ AGND 30k
C4004 Net-_C4003-Pad2_ AGND 22p
C4002 0 -62V 100u
R4012 Net-_Q4005-E_ -62V 56
Q4005 Net-_Q4002-C_ Net-_Q4003-C_ Net-_Q4005-E_ 2N5551
Q4004 Net-_Q4003-C_ Net-_Q4003-C_ Net-_Q4004-E_ 2N5551
R4011 Net-_Q4004-E_ -62V 56
C4005 Net-_C4005-Pad1_ AGND 470u
R4014 Net-_D4003-K_ -62V 680
D4003 Net-_D4003-A_ Net-_D4003-K_ 1N4148
R4013 +62V Net-_Q4006-C_ 180
C4006 Net-_C4006-Pad1_ Net-_Q4002-C_ 12p
R4003 +62V Net-_Q4001-E_ 330
Q4001 Net-_Q4001-C_ Net-_D4002-K_ Net-_Q4001-E_ 2N5401
R4006 Net-_Q4001-C_ Net-_R4006-Pad2_ 1.8k
R4005 Net-_Q4001-C_ Net-_Q4003-E_ 27
R4001 0 Net-_R4001-Pad2_ 10
RWJ4002 Net-_R4001-Pad2_ AGND 0.001
C4001 +62V 0 100u
R4002 Net-_D4002-K_ 0 22k
D4001 +62V Net-_D4001-K_ 1N4148
D4002 Net-_D4001-K_ Net-_D4002-K_ 1N4148
XRT4002 Net-_R4024-Pad2_ Net-_Q4010-E_ rpot_2_p value=100 pos={BIAS}
Q4007 Net-_Q4007-C_ Net-_D4004-A_ Net-_Q4007-E_ 2N5551
D4004 Net-_D4004-A_ Net-_D4004-K_ 1N4148
RWJ4009 Net-_Q4010-E_ Net-_Q4012-B_ 0.001
R4015 0 Net-_D4004-A_ 18k
R4018 Net-_D4006-K_ Net-_Q4007-C_ 180
C4007 Net-_C4007-Pad1_ Net-_Q4007-E_ 22u
RWJ4004 Net-_C4007-Pad1_ Net-_D4003-A_ 0.001
D4005 Net-_D4004-K_ -62V 1N4148
R4016 Net-_Q4007-E_ -62V 680
R4021 Net-_Q4009-E_ -62V 130
Q4009 Net-_Q4009-C_ Net-_D4003-A_ Net-_Q4009-E_ 2N5551
C4010 Net-_Q4009-C_ Net-_D4003-A_ 33p
C4011 Net-_Q4009-E_ -62V 100u
R4022 Net-_Q4012-B_ Net-_Q4009-C_ 43
Q4008 Net-_Q4008-C_ Net-_D4006-K_ Net-_Q4008-E_ 2N5401
R4020 Net-_Q4008-C_ Net-_Q4010-C_ 43
R4017 +62V Net-_D4006-A_ 680
R4019 +62V Net-_Q4008-E_ 130
D4006 Net-_D4006-A_ Net-_D4006-K_ 1N4148
R4024 Net-_Q4010-B_ Net-_R4024-Pad2_ 220
R4023 Net-_Q4010-C_ Net-_Q4010-B_ 910
C4008 Net-_Q4008-C_ Net-_D4006-K_ 33p
RWJ4007 Net-_WJ4007-Pad1_ Net-_RNTC4001-Pad2_ 0.001
RNTC4001 Net-_RNTC4001-Pad1_ Net-_RNTC4001-Pad2_ 2k
RWJ4006 Net-_WJ4005-Pad2_ Net-_RNTC4001-Pad1_ 0.001
RWJ4005 Net-_Q4010-C_ Net-_WJ4005-Pad2_ 0.001
C4012 Net-_Q4010-C_ Net-_Q4010-E_ 0.1u
C4009 +62V Net-_Q4008-E_ 100u
RWJ4008 Net-_Q4010-B_ Net-_WJ4007-Pad1_ 0.001
Q4010 Net-_Q4010-C_ Net-_Q4010-B_ Net-_Q4010-E_ 2N5551
R4030 Net-_Q4014-E_ PW_OUT 0.12
R4032 Net-_Q4015-E_ PW_OUT 0.12
Q4015 +62V Net-_Q4015-B_ Net-_Q4015-E_ 2SC5200
R4031 Net-_R4027-Pad1_ Net-_Q4015-B_ 0.47
Q4017 -62V Net-_Q4017-B_ Net-_Q4017-E_ 2SA1943
Q4018 -62V Net-_Q4018-B_ Net-_Q4018-E_ 2SA1943
R4037 Net-_Q4018-B_ Net-_R4033-Pad2_ 0.47
L4001 PW_OUT OUTPUT 1u
R4040 OUTPUT PW_OUT 2.2
R4038 PW_OUT Net-_Q4018-E_ 0.12
D4008 -62V PW_OUT 1N4007
R4039 PW_OUT Net-_C4013-Pad1_ 15
C4013 Net-_C4013-Pad1_ 0 0.1u
D4007 PW_OUT +62V 1N4007
RWJ4010 Net-_R4027-Pad1_ Net-_Q4011-E_ 0.001
Q4014 +62V Net-_Q4014-B_ Net-_Q4014-E_ 2SC5200
R4029 Net-_R4027-Pad1_ Net-_Q4014-B_ 0.47
Q4011 +62V Net-_Q4010-C_ Net-_Q4011-E_ MJE15034
R4027 Net-_R4027-Pad1_ Net-_Q4013-B_ 0.47
Q4013 +62V Net-_Q4013-B_ Net-_Q4013-E_ 2SC5200
R4025 Net-_Q4011-E_ PW_OUT 150
R4033 Net-_Q4016-B_ Net-_R4033-Pad2_ 0.47
R4035 Net-_Q4017-B_ Net-_R4033-Pad2_ 0.47
Q4016 -62V Net-_Q4016-B_ Net-_Q4016-E_ 2SA1943
R4036 PW_OUT Net-_Q4017-E_ 0.12
R4034 PW_OUT Net-_Q4016-E_ 0.12
R4028 Net-_Q4013-E_ PW_OUT 0.12
Q4012 -62V Net-_Q4012-B_ Net-_Q4012-E_ MJE15035
RWJ4011 Net-_R4033-Pad2_ Net-_Q4012-E_ 0.001
R4026 PW_OUT Net-_Q4012-E_ 150
.end
